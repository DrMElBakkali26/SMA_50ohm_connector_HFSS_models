# Ansys Electronics Desktop project, version 2023.1
materials:
  vacuum: permittivity=1
  Teflon (tm): permittivity=2.1 dielectric_loss_tangent=0.001

design HFSSDesign1 (HFSS, HFSS Modal Network, model units mm)
options: Save_Adaptive_support_files
geometry:
  SMA20S = imported_body(D:\Connectors Models By CST\BEST & USED SMA Connectors\IGES FILE.igs)
  SMA20S_1 [Teflon (tm)] = imported_body(D:\Connectors Models By CST\BEST & USED SMA Connectors\IGES FILE.igs)
  IGESFILE_Unnamed_1, SMA20S_2 = imported_body(D:\Connectors Models By CST\BEST & USED SMA Connectors\IGES FILE.igs)
  group IGESFILE = SMA20S, SMA20S_1, IGESFILE_Unnamed_1, SMA20S_2
